* Simple educational 180 nm MOS models for standalone pre-Crucible exercises.
.model NMOS18 nmos level=1 vto=0.45 kp=260u gamma=0.45 phi=0.7 lambda=0.08
.model PMOS18 pmos level=1 vto=-0.45 kp=90u gamma=0.40 phi=0.7 lambda=0.10

VDS d 0 0.9
VGS g 0 0.65
M1 d g 0 0 NMOS18 W=3.46u L=0.18u
.op
.end
